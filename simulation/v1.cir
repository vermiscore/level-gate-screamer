.title KiCad schematic
.include "/home/user/Desktop/myfolder/project/pcbs/my_tube_screamer/v1/pot_log.lib"
.include "/usr/share/kicad/symbols/Simulation_SPICE.sp"
.model __D3 D
.model __D4 D
.model __D2 D
.model __Q2 NPN level=4
.model __Q1 NJF
.model __D1 D
+           bv=5.1
.model __Q21 NPN level=4
.model __Q4 NJF
.model __Q6 NPN level=4
.model __D9 D
.model __D8 D
.model __Q7 NPN level=4
R21 GND JACK_OUT 100k
V9 JACK_IN GND DC 0 SIN( 0 0.2 1k 0 0 0 ) AC 1
V8 +9V GND DC 9
V7 Net-_#FLG0102-Pad1_ GND DC 4.5
R20 +9V +4.5V 10k
D3 GND +9V __D3
C28 +4.5V GND 100n
C27 +4.5V GND 100n
C18 +9V +4.5V 100n
D4 +9V LED_CATHODE __D4
R29 LED_CATHODE GND 2.2k
R31 LED_CATHODE Net-_R31-Pad2_ 2.2k
RJP21 vca_out JACK_OUT 0
RJP20 JACK_IN bf_in 0
C26 +4.5V GND 100n
C14 +9V GND 220u
C13 +9V GND 100n
R28 +4.5V GND 10k
C23 +4.5V GND 100n
C25 +4.5V GND 100n
C24 +4.5V GND 220u
C5 Net-_Q2-B_ Net-_C5-Pad2_ 10n
R7 Net-_Q2-B_ /vb 470k
D2 Net-_D2-A_ GND __D2
Q2 +9V Net-_Q2-B_ Net-_Q2-E_ __Q2
R13 Net-_Q2-E_ Net-_C12-Pad1_ 22k
R11 bf_out Net-_C5-Pad2_ 10k
R6 bf_out GND 2.2Meg
JQ1 Net-_Q1-D_ Net-_Q1-G_ /vb __Q1
R12 Net-_Q1-D_ /vb 1Meg
C1 Net-_C1-Pad1_ GND 2.2u
R333 Net-_U5-VOUT_ Net-_U5-VIN-_ 1Meg
XU5 Net-_U5-VIN+_ Net-_U5-VIN-_ +9V GND Net-_U5-VOUT_ kicad_builtin_opamp
C6 Net-_Q2-E_ Net-_C6-Pad2_ 10n
C7 Net-_C12-Pad1_ Net-_Q1-D_ 10u
R4 Net-_D2-A_ +9V 3.3k
C8 +9V GND 10u
D1 GND /vb __D1
C9 /vb GND 10u
R3 /vb +9V 22k
R555 Net-_Q2-E_ GND 22k
R10 Net-_POT2-Pad1_ /vb 1k
XPOT2 Net-_POT2-Pad1_ Net-_U5-VIN+_ Net-_C6-Pad2_ POT_LOG POS=0.5
C10 Net-_C10-Pad1_ Net-_U2-VIN-_ 47n
R18 Net-_Q1-G_ Net-_C10-Pad1_ 1Meg
R8 q21_c Net-_Q21-B_ 1Meg
R222 Net-_C2-Pad2_ GND 22k
C3 Net-_C2-Pad2_ Net-_U5-VOUT_ 47n
R444 Net-_Q21-B_ Net-_C2-Pad2_ 100k
Q21 q21_c Net-_Q21-B_ GND __Q21
R9 q21_c /vb 150k
C4 q21_c GND 1u
R19 ns_out ns_out2 100
R16 ns_out2 GND 10k
C11 Net-_U2-VIN-_ ns_out2 10u
XU2 Net-_U2-VIN+_ Net-_U2-VIN-_ +9V GND Net-_U2-VIN-_ kicad_builtin_opamp
R5 Net-_U2-VIN+_ +9V 1Meg
R17 GND Net-_U2-VIN+_ 1Meg
R14 q21_c Net-_Q1-G_ 1.8k
R15 /vb Net-_C10-Pad1_ 100k
C12 Net-_C12-Pad1_ Net-_U2-VIN+_ 10n
C2 Net-_Q21-B_ Net-_C2-Pad2_ 10n
R111 Net-_U5-VIN-_ Net-_C1-Pad1_ 4.7k
C38 Net-_U8-VOUT_ bf_out 100u
XU8 Net-_U8-VIN+_ Net-_U8-VIN-_ +9V GND Net-_U8-VOUT_ kicad_builtin_opamp
R58 Net-_C37-Pad1_ Net-_U8-VIN+_ 10k
R61 GND bf_out 100
R59 Net-_R56-Pad2_ +9V 100k
R60 Net-_U8-VIN-_ Net-_U8-VOUT_ 10
C35 GND Net-_C35-Pad2_ 4.7u
C36 Net-_C36-Pad1_ TS_OUT 0.1u
R49 GND TS_OUT 22Meg
R52 Net-_C36-Pad1_ Net-_U9-VIN+_ 1k
R51 +4.5V Net-_C36-Pad1_ 10Meg
R62 GND ota_out 10k
C40 Net-_C40-Pad1_ Net-_U9-VOUT_ 15u
R54 Net-_C40-Pad1_ ota_out 470
R50 Net-_C35-Pad2_ Net-_POT3-Pad2_ 2.7k
RPOT3 Net-_U9-VIN-_ Net-_POT3-Pad2_ 200k
C39 Net-_U9-VOUT_ Net-_U9-VIN-_ 47p
R53 Net-_U9-VIN-_ Net-_U9-VOUT_ 56k
XU9 Net-_U9-VIN+_ Net-_U9-VIN-_ +9V GND Net-_U9-VOUT_ kicad_builtin_opamp
XU6 Net-_Q4-D_ Net-_U6-VIN-_ +9V GND Net-_U6-VIN-_ kicad_builtin_opamp
R35 Net-_C16-Pad1_ Net-_U6-VIN-_ 200k
C16 Net-_C16-Pad1_ Net-_Q4-G_ 1u
R38 GND vca_out 10k
C17 vca_out Net-_U6-VIN-_ 1u
R33 Net-_Q4-G_ q21_c 9.53k
R34 /vb Net-_Q4-D_ 1Meg
C15 ota_out Net-_C15-Pad2_ 10u
JQ4 Net-_Q4-D_ Net-_Q4-G_ /vb __Q4
R32 Net-_Q4-D_ Net-_C15-Pad2_ 100k
RPOT4 Net-_POT4-Pad1_ Net-_D8-A_ 0
C50 Net-_C50-Pad1_ Net-_C50-Pad2_ 220n
R26 Net-_POT4-Pad1_ Net-_D8-K_ 47k
RPOT7 Net-_U1-VIN-_ Net-_C50-Pad1_ 11k
C21 Net-_D8-K_ Net-_C21-Pad2_ 47n
R23 +4.5V Net-_C21-Pad2_ 4.7k
R25 Net-_U3-VIN+_ +4.5V 10k
XU3 Net-_U3-VIN+_ Net-_D8-K_ +9V GND Net-_D8-A_ kicad_builtin_opamp
R27 Net-_U1-VIN+_ Net-_D8-A_ 1k
C46 GND Net-_U1-VIN+_ 220n
R63 +4.5V Net-_U1-VIN+_ 10k
R56 GND Net-_R56-Pad2_ 100k
R57 Net-_C37-Pad1_ Net-_R56-Pad2_ 2.2Meg
C37 Net-_C37-Pad1_ bf_in 100n
R55 GND bf_in 2.2Meg
R223 Net-_Q6-B_ +4.5V 470k
C19 Net-_C19-Pad1_ ns_out 22n
R211 Net-_Q6-B_ Net-_C19-Pad1_ 1k
R24 Net-_Q6-E_ GND 10k
Q6 +9V Net-_Q6-B_ Net-_Q6-E_ __Q6
C20 Net-_U3-VIN+_ Net-_Q6-E_ 1u
C22 Net-_D8-A_ Net-_D8-K_ 47p
D9 Net-_D8-K_ Net-_D8-A_ __D9
D8 Net-_D8-A_ Net-_D8-K_ __D8
R64 Net-_U1-VIN-_ Net-_U1-VOUT_ 1k
R65 Net-_C50-Pad2_ GND 220
XU1 Net-_U1-VIN+_ Net-_U1-VIN-_ +9V GND Net-_U1-VOUT_ kicad_builtin_opamp
Q7 +9V Net-_Q7-B_ Net-_Q7-E_ __Q7
RPOT8 Net-_POT8-Pad1_ connected 10
R70 Net-_Q7-E_ GND 10k
R72 TS_OUT GND 10k
R71 Net-_C54-Pad2_ Net-_Q7-E_ 100
C54 TS_OUT Net-_C54-Pad2_ 10u
C52 Net-_C52-Pad1_ Net-_U1-VOUT_ 1u
C53 Net-_Q7-B_ connected 100n
R67 connected +4.5V 10k
R69 Net-_Q7-B_ +4.5V 470k
R66 Net-_C52-Pad1_ Net-_POT8-Pad1_ 1k
.end
